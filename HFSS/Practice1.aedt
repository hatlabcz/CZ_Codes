# Ansys Electronics Desktop project, version 2017.0
materials:
  vacuum: permittivity=1
  steel_stainless: conductivity=1100000
  Polyflon CuFlon (tm): permittivity=2.1 dielectric_loss_tangent=0.00045
  sapphire: permittivity=10
  aluminum: permeability=1.000021 conductivity=38000000
  perfect conductor: conductivity=1e+030

design HFSSDesign1 (HFSS, Eigenmode, model units mm)
geometry:
  cavity = cylinder(axis=Z, base_centre=(0mm, 0mm, 0mm), radius=3.81mm, height=10.668mm)
  cavity.rotate(axis=Y, angle=90deg)
  Cylinder1_1 = cavity.duplicate_along_line(step=(0mm, 35.56mm, 0mm), total=2)
  Box1 = box(corner=(0mm, 0mm, -3.81mm), size=(10.668mm, 35.56mm, 7.62mm))
  cavity.unite(Cylinder1_1, Box1)
  Cylinder1_2 = cavity.duplicate_along_line(step=(10.668mm, 0mm, 0mm), total=2)
  cavity.unite(Cylinder1_2)
  cavity_1 [vacuum] = cylinder(axis=Z, base_centre=(5.588mm, 17.78mm, 3.556mm), radius=0.254mm, height=7.874mm)
  cable_inner_2 = cavity_1.duplicate_along_line(step=(10.16mm, 0mm, 0mm), total=2)
  Cylinder5 = cylinder(axis=Z, base_centre=(5.588mm, 17.78mm, 3.81mm), radius=0.254mm, height=-0.254mm)
  Cylinder5_1 = Cylinder5.duplicate_along_line(step=(10.16mm, 2.8199665e-15mm, 0mm), total=2)
  cavity.subtract(Cylinder5, Cylinder5_1)
  coordinate_system RelativeCS1 = origin=(10.668mm, 17.78mm, 0mm) x=(25.4mm, 0mm, 0mm) y=(0mm, 25.4mm, 0mm)
  Box2 = box(corner=(-0.15mm, -1.5mm, -5mm), size=(0.3mm, 3mm, 10mm)) in RelativeCS1
  antenna_top [perfect conductor, non-model] = box(corner=(0mm, -0.125mm, 0.05mm), size=(100nm, 0.25mm, 1.1mm)) in RelativeCS1
  antenna_bottom [perfect conductor, non-model] = antenna_top.duplicate_along_line(step=(0mm, 0mm, -1.2mm), total=2) in RelativeCS1
  [antenna_top, antenna_bottom].move(0.15mm, 0mm, 0mm) in RelativeCS1
  cavity.subtract(Box2)
  sapphire_substrate [sapphire] = box(corner=(-0.15mm, -1.5mm, -5mm), size=(0.3mm, 3mm, 10mm)) in RelativeCS1
  coordinate_system RelativeCS2 = origin=(0.15mm, -1.5mm, 3.81mm) x=(25.4mm, 0mm, 0mm) y=(0mm, 25.4mm, 0mm) in RelativeCS1
  [cavity_1, cable_inner_2].split(plane=XY, keep=Both) in RelativeCS2
  cavity_1.unite(cable_inner_2, cavity)
  antenna_top_1 = antenna_top.duplicate_along_line(step=(0mm, 0mm, -0.1mm), total=2)
  coordinate_system RelativeCS3 = origin=(10.818mm, ((((17905-115)*0.039370078740157)*25.4)*0.001) mm, 0.05mm) x=(25.4mm, 0mm, 0mm) y=(0mm, 25.4mm, 0mm)
  antenna_top_1.split(plane=XY, keep=NegativeOnly) in RelativeCS3
  antenna_top_1.split(plane=ZX, keep=NegativeOnly) in RelativeCS3
  coordinate_system RelativeCS4 = origin=(0mm, -0.02mm, 0mm) x=(0.001mm, 0mm, 0mm) y=(0mm, 0.001mm, 0mm) in RelativeCS3
  antenna_top_1.split(plane=ZX, keep=PositiveOnly) in RelativeCS4
  coordinate_system RelativeCS5 = origin=(0mm, 0mm, -0.04mm) x=(0.001mm, 0mm, 0mm) y=(0mm, 0.001mm, 0mm) in RelativeCS4
  antenna_top_1_Split1 = antenna_top_1.split(plane=XY, keep=Both) in RelativeCS5
  antenna_top.unite(antenna_top_1_Split1)
  coordinate_system RelativeCS6 = origin=(0mm, 0mm, -0.02mm) x=(0.001mm, 0mm, 0mm) y=(0mm, 0.001mm, 0mm) in RelativeCS5
  antenna_top_1.split(plane=XY, keep=NegativeOnly) in RelativeCS6
  antenna_bottom.unite(antenna_top_1)
  coordinate_system RelativeCS7 = origin=(10.8181mm, 17.77mm, 0.05mm) x=(0.0254mm, 0mm, 0mm) y=(0mm, 0.0254mm, 0mm)
  antenna_top.split(plane=XY, keep=PositiveOnly) in RelativeCS7
  coordinate_system RelativeCS8 = origin=(0mm, 0mm, -0.1mm) x=(0.0254mm, 0mm, 0mm) y=(0mm, 0.0254mm, 0mm) in RelativeCS7
  antenna_bottom.split(plane=XY, keep=NegativeOnly) in RelativeCS8
  antenna_top_2 = antenna_top.duplicate_along_line(step=(0mm, 0mm, -0.1mm), total=2) in RelativeCS8
  coordinate_system RelativeCS9 = origin=(0mm, -0.115mm, 0.1mm) x=(0.001mm, 0mm, 0mm) y=(0mm, 0.001mm, 0mm) in RelativeCS8
  antenna_top_2.split(plane=XY, keep=NegativeOnly) in RelativeCS9
  coordinate_system RelativeCS10 = origin=(0mm, 0.12mm, 0mm) x=(0.001mm, 0mm, 0mm) y=(0mm, 0.001mm, 0mm) in RelativeCS9
  antenna_top_2.split(plane=ZX, keep=PositiveOnly) in RelativeCS10
  coordinate_system RelativeCS11 = origin=(0mm, 0.01mm, 0mm) x=(0.001mm, 0mm, 0mm) y=(0mm, 0.001mm, 0mm) in RelativeCS10
  antenna_top_2.split(plane=ZX, keep=NegativeOnly) in RelativeCS11
  coordinate_system RelativeCS12 = origin=(0mm, 0mm, -0.045mm) x=(0.001mm, 0mm, 0mm) y=(0mm, 0.001mm, 0mm) in RelativeCS11
  antenna_top_2_Split1 = antenna_top_2.split(plane=XY, keep=Both) in RelativeCS12
  coordinate_system RelativeCS13 = origin=(0mm, 0mm, -0.01mm) x=(0.001mm, 0mm, 0mm) y=(0mm, 0.001mm, 0mm) in RelativeCS12
  antenna_top_2.split(plane=XY, keep=NegativeOnly) in RelativeCS13
  antenna_bottom.unite(antenna_top_2)
  antenna_top.unite(antenna_top_2_Split1)
  Rectangle1 [non-model] = rectangle(corner=(0mm, -0.01mm, 0.01mm), y_size=0.01mm, z_size=-0.01mm) in RelativeCS13
  Rectangle1_1 [non-model] = Rectangle1.duplicate_along_line(step=(-0.0001mm, 0mm, 0mm), total=2) in RelativeCS13
mesh:
  cavity: LengthBased RefineInside Objects=cavity_1 NumMaxElem=1000 MaxLength=10mm
  initial mesh: MeshMethod=AnsoftClassic
setups:
  Setup1: HfssEigen MinimumFrequency=3.47383GHz NumModes=5 MaxDeltaFreq=10 ConvergeOnRealFreq=false MaximumPasses=3 MinimumPasses=1 MinimumConvergedPasses=1 PercentRefinement=30 BasisOrder=1
source amplitudes:
  #-10:1: 1 0deg
  #-10:2..#-10:5: 0 0deg
field plots:
  Vector_H1: H Field in cavity_1 on Setup1 : LastAdaptive at Phase=0deg
