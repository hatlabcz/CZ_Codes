# Ansys Electronics Desktop project, version 2017.0
materials:
  vacuum: permittivity=1

design HFSSDesign1 (HFSS, Eigenmode, model units mm)
variables:
  length = 8in
geometry:
  Box1 [vacuum] = box(corner=(0mm, 0mm, 0mm), size=(0.622in, length, 0.8in))
setups:
  Setup1: HfssEigen MinimumFrequency=0.98425GHz NumModes=5 MaxDeltaFreq=10 ConvergeOnRealFreq=false MaximumPasses=3 MinimumPasses=1 MinimumConvergedPasses=1 PercentRefinement=30 BasisOrder=1
source amplitudes:
  #-10:1: 1 0deg
  #-10:2..#-10:5: 0 0deg
